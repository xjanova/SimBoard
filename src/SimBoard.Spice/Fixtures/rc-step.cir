* SimBoard fixture — RC step response
* Analytically exact: tau = R1*C1 = 10k * 10n = 100 us
* v(out) at t=tau must be 5 * (1 - 1/e) = 3.16060 V
V1 in 0 PULSE(0 5 0 1n 1n 10m 20m)
R1 in out 10k
C1 out 0 10n
.tran 200n 1m
.end
